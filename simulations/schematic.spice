** SCHEMATIC flat netlist
*--------BEGIN_XM8->SG13_HV_PMOS
XM8 NET8 NET8 NET1 NET2  SG13_HV_PMOS W=1.0U L=0.72U NG=1 M=1 RFMODE=1
*--------END___XM8->SG13_HV_PMOS
*--------BEGIN_XM5->SG13_HV_NMOS
XM5 NET8 NET11 NET9 0  SG13_HV_NMOS W=1.0U L=0.72U NG=1 M=1 RFMODE=1
*--------END___XM5->SG13_HV_NMOS
*--------BEGIN_XR1->RHIGH
XR1 NET30 NET4 SUB!  RHIGH W=0.5E-6 L=04E-6 M=1 B=0
*--------END___XR1->RHIGH
*--------BEGIN_XM4->SG13_HV_NMOS
XM4 NET3 NET3 NET7 0  SG13_HV_NMOS W=1.0U L=0.72U NG=1 M=1 RFMODE=1
*--------END___XM4->SG13_HV_NMOS
*--------BEGIN_XM1->SG13_HV_NMOS
XM1 NET9 NET3 NET6 0  SG13_HV_NMOS W=1.0U L=0.72U NG=1 M=1 RFMODE=1
*--------END___XM1->SG13_HV_NMOS
*--------BEGIN_XM7->SG13_HV_PMOS
XM7 NET10 NET1 NET2 NET2  SG13_HV_PMOS W=1.0U L=0.72U NG=1 M=1 RFMODE=1
*--------END___XM7->SG13_HV_PMOS
*--------BEGIN_XM2->SG13_HV_PMOS
XM2 NET1 NET1 NET2 NET2  SG13_HV_PMOS W=1.0U L=0.72U NG=1 M=1 RFMODE=1
*--------END___XM2->SG13_HV_PMOS
*--------BEGIN_XQ1->NPN13G2
XQ1 NET4 NET4 0 0  NPN13G2 NX=10
*--------END___XQ1->NPN13G2
*--------BEGIN_XQ2->NPN13G2
XQ2 NET5 NET5 0 0  NPN13G2 NX=1
*--------END___XQ2->NPN13G2
*--------BEGIN_XM9->SG13_HV_PMOS
XM9 NET12 NET1 NET2 NET2  SG13_HV_PMOS W=1.0U L=0.72U NG=1 M=1 RFMODE=1
*--------END___XM9->SG13_HV_PMOS
*--------BEGIN_XM3->SG13_HV_PMOS
XM3 NET11 NET8 NET10 NET2  SG13_HV_PMOS W=1.0U L=0.72U NG=1 M=1 RFMODE=1
*--------END___XM3->SG13_HV_PMOS
*--------BEGIN_XM6->SG13_HV_NMOS
XM6 NET11 NET11 NET3 0  SG13_HV_NMOS W=1.0U L=0.72U NG=1 M=1 RFMODE=1
*--------END___XM6->SG13_HV_NMOS
*--------BEGIN_XM10->SG13_HV_PMOS
XM10 NET15 NET8 NET12 NET2  SG13_HV_PMOS W=1.0U L=0.72U NG=1 M=1 RFMODE=1
*--------END___XM10->SG13_HV_PMOS
*--------BEGIN_XR10->PTAP1
XR10 SUB! 0  PTAP1 R=262.8473 W=0.78E-6 L=0.78E-6
*--------END___XR10->PTAP1
*--------BEGIN_XM22->SG13_HV_NMOS
XM22 NET13 NET13 0 0  SG13_HV_NMOS W=1.0U L=0.72U NG=1 M=1 RFMODE=1
*--------END___XM22->SG13_HV_NMOS
*--------BEGIN_XM23->SG13_HV_NMOS
XM23 NET14 NET14 NET13 0  SG13_HV_NMOS W=1.0U L=0.72U NG=1 M=1 RFMODE=1
*--------END___XM23->SG13_HV_NMOS
V1 NET2 0 3
V3 NET14 NET15 0
*--------BEGIN_XM11->SG13_HV_PMOS
XM11 NET24 NET19 NET2 NET2  SG13_HV_PMOS W=1.0U L=0.72U NG=1 M=1 RFMODE=1
*--------END___XM11->SG13_HV_PMOS
*--------BEGIN_XM12->SG13_HV_PMOS
XM12 NET16 NET19 NET2 NET2  SG13_HV_PMOS W=1.0U L=0.72U NG=1 M=1 RFMODE=1
*--------END___XM12->SG13_HV_PMOS
*--------BEGIN_XM13->SG13_HV_NMOS
XM13 NET24 NET8 NET18 0  SG13_HV_NMOS W=1.0U L=0.72U NG=1 M=1 RFMODE=1
*--------END___XM13->SG13_HV_NMOS
*--------BEGIN_XM14->SG13_HV_NMOS
XM14 NET16 NET22 NET17 0  SG13_HV_NMOS W=1.0U L=0.72U NG=1 M=1 RFMODE=1
*--------END___XM14->SG13_HV_NMOS
*--------BEGIN_XM15->SG13_HV_NMOS
XM15 NET26 NET20 0 0  SG13_HV_NMOS W=1.0U L=0.72U NG=1 M=1 RFMODE=1
*--------END___XM15->SG13_HV_NMOS
*--------BEGIN_XM18->SG13_HV_NMOS
XM18 NET20 NET20 0 0  SG13_HV_NMOS W=1.0U L=0.72U NG=1 M=1 RFMODE=1
*--------END___XM18->SG13_HV_NMOS
*--------BEGIN_XM19->SG13_HV_NMOS
XM19 NET22 NET22 NET20 0  SG13_HV_NMOS W=1.0U L=0.72U NG=1 M=2 RFMODE=1
*--------END___XM19->SG13_HV_NMOS
*--------BEGIN_XM20->SG13_HV_PMOS
XM20 NET19 NET19 NET2 NET2  SG13_HV_PMOS W=1.0U L=0.72U NG=1 M=2 RFMODE=1
*--------END___XM20->SG13_HV_PMOS
*--------BEGIN_XR4->RHIGH
XR4 NET2 NET21 SUB!  RHIGH W=0.5E-6 L=30E-6 M=1 B=0
*--------END___XR4->RHIGH
*--------BEGIN_XR5->RHIGH
XR5 NET21 NET22 SUB!  RHIGH W=0.5E-6 L=30E-6 M=1 B=0
*--------END___XR5->RHIGH
*--------BEGIN_XR6->RHIGH
XR6 NET19 NET23 SUB!  RHIGH W=0.5E-6 L=30E-6 M=1 B=0
*--------END___XR6->RHIGH
*--------BEGIN_XR7->RHIGH
XR7 NET23 0 SUB!  RHIGH W=0.5E-6 L=30E-6 M=1 B=0
*--------END___XR7->RHIGH
*--------BEGIN_XM21->SG13_HV_NMOS
XM21 NET25 NET16 0 0  SG13_HV_NMOS W=1.0U L=0.72U NG=1 M=1 RFMODE=1
*--------END___XM21->SG13_HV_NMOS
V2 NET25 NET1 0
V4 NET26 NET17 0
V5 NET26 NET18 0
*--------BEGIN_XM16->SG13_HV_PMOS
XM16 NET28 NET1 NET2 NET2  SG13_HV_PMOS W=10.0U L=0.72U NG=1 M=1 RFMODE=1
*--------END___XM16->SG13_HV_PMOS
*--------BEGIN_XM17->SG13_HV_NMOS
XM17 NET29 NET27 0 0  SG13_HV_NMOS W=10.0U L=0.72U NG=1 M=1 RFMODE=1
*--------END___XM17->SG13_HV_NMOS
V6 NET27 NET13 SIN(0 1M 100K 0 0 0)
V7 NET29 NET28 0
V8 NET5 NET6 0
V9 NET30 NET7 0
**** BEGIN USER ARCHITECTURE CODE

.TRAN 0.1N 10U
.lib cornerMOSlv.lib mos_tt
.lib cornerMOShv.lib mos_tt
.lib cornerHBT.lib hbt_typ
.lib cornerRES.lib res_typ
.lib cornerDIO.lib dio_tt
.PARAM TEMP=27
.SAVE ALL
.control
run
write tran_sim.raw
.options savecurrents
.endc

**** END USER ARCHITECTURE CODE
.end
